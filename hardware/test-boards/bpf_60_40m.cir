* LA7LKA QRP SDR TRX - RX band-pass filter, 60m+40m (filter 3 of 6)
* 5th-order Butterworth bandpass, LC ladder: shunt-series-shunt-series-shunt
* Lower cutoff 5.35 MHz, upper cutoff 7.2 MHz, Rs=RL=50 ohm
*
* Derived from the Butterworth N=5 lowpass prototype (g1=g5=0.618034,
* g2=g4=1.618034, g3=2.0) via the exact bandpass frequency transform
* (not the narrowband J-inverter approximation), then verified numerically
* against an ABCD-matrix cascade: S21 = -3.01 dB at both 5.35 MHz and
* 7.2 MHz, 0 dB (no ripple) in the passband, -23.6 dB at 8 MHz,
* -52 dB at 10 MHz. All component values came out positive - no
* negative-capacitance absorption step needed, unlike the
* "Direct-Coupled, Series Capacitor" topology markimicrowave.com's
* calculator was using.
*
* AC 2 on V1 so V(out) plots directly as S21 in dB/phase (matched
* source/load: a 0 dB-through network gives V(out) = V1/2 = 1, i.e. 0 dB,
* when V1's open-circuit amplitude is 2).

V1   vin  0   AC 2
Rs   vin  1   50

* Resonator 1 (shunt, node 1)
L1   1    0   618.39n
C1   1    0   1063.386p

* Resonator 2 (series, node 1 -> node 2)
L2   1    2   6959.95n
C2   2    3   94.482p

* Resonator 3 (shunt, node 3 - band centre)
L3   3    0   191.09n
C3   3    0   3441.188p

* Resonator 4 (series, node 3 -> node 5)
L4   3    4   6959.95n
C4   4    5   94.482p

* Resonator 5 (shunt, node 5)
L5   5    0   618.39n
C5   5    0   1063.386p

RL   5    0   50

.ac dec 200 500k 20Meg
.net I(RL) V1
.end
